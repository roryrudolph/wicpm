simulator( 'spectre )
design(	 "/nethome/rrudolph3/Desktop/wicpm/ami06/simulation/inv/spectre/schematic/netlist/netlist")
resultsDir( "/nethome/rrudolph3/Desktop/wicpm/ami06/simulation/inv/spectre/schematic" )
modelFile(
    '("/tools/solsoft/solcad/ic610/ncsu-cdk-1.6.0.beta/models/spectre/standalone/ami06N.m" "")
    '("/tools/solsoft/solcad/ic610/ncsu-cdk-1.6.0.beta/models/spectre/standalone/ami06P.m" "")
)
analysis('tran ?stop "100u"  )
envOption(
	'analysisOrder  list("tran")
)
temp( 27 )
run()
selectResult( 'tran )
plot(getData("/VIN") getData("/VOUT") )
modelFile(
    '("/tools/solsoft/solcad/ic610/ncsu-cdk-1.6.0.beta/models/spectre/standalone/ami06N.m" "")
    '("/tools/solsoft/solcad/ic610/ncsu-cdk-1.6.0.beta/models/spectre/standalone/ami06P.m" "")
)
analysis('tran ?stop "10n"  )
run()
selectResult( 'tran )
plot(getData("/VIN") getData("/VOUT") )
modelFile(
    '("/tools/solsoft/solcad/ic610/ncsu-cdk-1.6.0.beta/models/spectre/standalone/ami06N.m" "")
    '("/tools/solsoft/solcad/ic610/ncsu-cdk-1.6.0.beta/models/spectre/standalone/ami06P.m" "")
)
analysis('tran ?stop "100n"  )
run()
selectResult( 'tran )
plot(getData("/VIN") getData("/VOUT") )
