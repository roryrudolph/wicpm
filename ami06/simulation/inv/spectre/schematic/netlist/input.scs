// Design: lib6414/inv
simulator lang=spectre
global 0 vdd!
include "/tools/solsoft/solcad/ic610/ncsu-cdk-1.6.0.beta/models/spectre/standalone/ami06N.m"
include "/tools/solsoft/solcad/ic610/ncsu-cdk-1.6.0.beta/models/spectre/standalone/ami06P.m"

// lib6414/inv/schematic
V0 (vdd! 0) vsource type=dc dc=5
V1 (VIN 0) vsource type=pulse val0=0 val1=5 rise=1n
N0 (VOUT VIN 0 0) ami06N w=1.5u l=600n m=1 region=sat
P0 (VOUT VIN vdd! vdd!) ami06P w=1.5u l=600n m=1 region=sat
C0 (VOUT 0) capacitor c=1p m=1
simulatorOptions options temp=27
tran tran stop=100n
